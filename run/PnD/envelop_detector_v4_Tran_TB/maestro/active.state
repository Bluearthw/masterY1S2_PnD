ADE simulation setup
Test PnD_envelop_detector_v4_Tran_TB_1: PnD/envelop_detector_v4_Tran_TB/schematic, simulator spectre
  Models: /esat/micas-data/data/design/tsmc65_students/PDK/tsmcN65//../models/spectre/toplevel.scs[tt_lib]
  Variables: C_env1 = 1n; Cload = 10n; fin = 20k; VDD = 1.4; vin = 1m,50m,100m,1; VSS = -1.4
  Temperature: 27
  Analysis tran: stop=10/VAR("fin")
  Signals: /vrf, /vout, /I4/net4
Run mode: Single Run, Sweeps and Corners
