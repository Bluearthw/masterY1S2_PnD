ADE simulation setup
Run mode: Single Run, Sweeps and Corners
Tests:
  PnD_envelop_detector_v4_Tran_TB_1: PnD/envelop_detector_v4_Tran_TB/schematic, simulator spectre
    Variables: C_env1 = 1n; Cload = 10n; fin = 20k; VDD = 1.4; vin = 1m,50m,100m,1; VSS = -1.4
    Outputs: /I4/net4
