ADE simulation setup
Test PnD_lbl_mix_test_1: PnD/lbl_mix_test_PNOISE/config, simulator ams
  Models: /esat/micas-data/data/design/tsmc65_students/PDK/tsmcN65//../models/spectre/toplevel.scs[mismatch_lib]
  Variables: fclk = 16M; fin = 20k; sw1 = 1.4; sw2 = 1.4; sw3 = 1.4; sw4 = 1.4; sw5 = 1.4; sw6 = 1.4; vac = 1; vcm = 0.682; VDD = 1.4; vin = 100m; VSS = 0
  Temperature: 27
  Analysis noise: start=1 stop=1G p=/cmp_out_+ n=/cmp_out_- iprobe=/V14
  Analysis dc: (saves the operating point)
  Output VN2() = VN2()
  Output integ(VN2() 10 1000000.0)
  Signals: /adc_out, /vraw, /vin
