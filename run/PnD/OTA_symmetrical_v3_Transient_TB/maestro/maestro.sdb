ADE simulation setup
Run mode: Single Run, Sweeps and Corners
Tests:
  PnD_OTA_symmetrical_v3_Transient_TB_1: PnD/OTA_symmetrical_v3_Transient_TB/schematic, simulator spectre
    Variables: Ibias = 0.2; Vbleed = -0.278; VDD = 0.7; vin = 1; VSS = -0.7
