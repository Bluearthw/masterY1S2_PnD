ADE simulation setup
Test PnD_OTA_symmetrical_v3_Transient_TB_1: PnD/OTA_symmetrical_v3_Transient_TB/schematic, simulator spectre
  Models: /esat/micas-data/data/design/tsmc65_students/PDK/tsmcN65//../models/spectre/toplevel.scs[tt_lib]
  Variables: Ibias = 0.2; Vbleed = -0.278; VDD = 0.7; vin = 1; VSS = -0.7
  Temperature: 27
  Analysis ac: start=1 stop=1T dec=10
  Analysis dc: (saves the operating point)
  Analysis tran: stop=100u
  Output v /vout; ac dB20(V) = db(vfreq('ac "/vout"))
  Output v /vout; ac deg(V) = phaseDegUnwrapped(vfreq('ac "/vout"))
  Signals: /vout
Run mode: Single Run, Sweeps and Corners
