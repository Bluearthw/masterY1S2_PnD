ADE simulation setup
Run mode: Single Run, Sweeps and Corners
Tests:
  gmoverid_plots_pch_hvt: PnD/gmoverid_plots_hvt/schematic, simulator spectre
    Variables: Lp = 360n; NFp = 1; WFp = 5u; VGSp = -500m; VDSp = -300m; VSBp = 0; Ln = 360n; NFn = 10; WFn = 1.5u; VGSn = 500m; VDSn = 500m; VSBn = 0
    Outputs: IDn; |IDp|; gm,n; gm,p; gm/ID,p; gm/ID,n; fT,n; fT,p; (Aintr,n)dB; (Aintr,p)dB; fT,n*Aintr,n; fT,p*Aintr,p; gm,n vs gm/ID,n; gm,p vs gm/ID,p; fT,n vs gm/ID,n; fT,p vs gm/ID,p; Aintr,n vs gm/ID,n; Aintr,p vs gm/ID,p; fT,n*Aintr,n vs gm/ID,n; fT,p*Aintr,p vs gm/ID,p; ID,n/W vs gm/ID,n; |ID,p|/W vs gm/ID,p; OS("/NM0" "gm"); Vth,n; |Vth,p|; 1/gds,n; 1/gds,p; 1/gds,n vs gm/ID,n; 1/gds,p vs gm/ID,p
  gmoverid_plots_nch_hvt: PnD/gmoverid_plots_hvt/schematic, simulator spectre
    Variables: Ln = 360n; NFn = 1; WFn = 200n; VGSn = 1300m; VDSn = 1300m; VSBn = 0; Lp = 360n; NFp = 10; WFp = 1u; VGSp = -500m; VDSp = -500m; VSBp = 0
    Outputs: IDn; |IDp|; gm,n; gm,p; gm/ID,p; gm/ID,n; fT,n; fT,p; (Aintr,n)dB; (Aintr,p)dB; fT,n*Aintr,n; fT,p*Aintr,p; gm,n vs gm/ID,n; gm,p vs gm/ID,p; fT,n vs gm/ID,n; fT,p vs gm/ID,p; Aintr,n vs gm/ID,n; Aintr,p vs gm/ID,p; fT,n*Aintr,n vs gm/ID,n; fT,p*Aintr,p vs gm/ID,p; ID,n/W vs gm/ID,n; |ID,p|/W vs gm/ID,p; OS("/NM0" "gm"); Vth,n; |Vth,p|; 1/gds,n; 1/gds,p; 1/gds,n vs gm/ID,n; 1/gds,p vs gm/ID,p
Global variables:
  Ln = 45n
Specs:
  gmoverid_plots_pch_hvt / gm,p: > 0.018
  gmoverid_plots_pch_hvt / fT,p*Aintr,p: > 690M
  gmoverid_plots_nch_hvt / gm,p: > 0.018
  gmoverid_plots_nch_hvt / fT,p*Aintr,p: > 690M
