ADE simulation setup
Test DAMSIC_2023_gmoverid_plots_1: PnD/gmoverid_plots/schematic, simulator spectre
  Models: /esat/micas-data/data/design/generic/045/gpdk045_v_4_0/gpdk045/../models/spectre/gpdk045.scs[mc]
  Variables: Ln = 360n; NFn = 10; WFn = 1.5u; VGSn = 500m; VDSn = 500m; VSBn = 0; Lp = 360n; NFp = 10; WFp = 1u; VGSp = -500m; VDSp = -500m; VSBp = 0
  Temperature: 27
  Analysis dc: sweep VGSp start=-1 stop=0 step=10m (saves the operating point)
  Output |Vth,p| = abs(OS("/PM0" "vth"))
  Output |IDp| = abs(IS("/PM0/D"))
  Output gm,p = OS("/PM0" "gm")
  Output 1/gds,p = (1 / OS("/PM0" "gds"))
  Output gm/ID,p = OS("/PM0" "gmoverid")
  Output fT,p = (OS("/PM0" "gm") / (2 * pi * OS("/PM0" "cgg")))
  Output (Aintr,p)dB = dB20((OS("/PM0" "gm") / OS("/PM0" "gds")))
  Output fT,p*Aintr,p = ((OS("/PM0" "gm") / (2 * pi * OS("/PM0" "cgg"))) * (OS("/PM0" "gm") / OS("/PM0" "gds")))
  Output gm,p vs gm/ID,p = waveVsWave(?x OS("/PM0" "gmoverid") ?y OS("/PM0" "gm"))
  Output 1/gds,p vs gm/ID,p = waveVsWave(?x OS("/PM0" "gmoverid") ?y (1 / OS("/PM0" "gds")))
  Output fT,p vs gm/ID,p = waveVsWave(?x OS("/PM0" "gmoverid") ?y (OS("/PM0" "gm") / (2 * pi * OS("/PM0" "cgg"))))
  Output Aintr,p vs gm/ID,p = waveVsWave(?x OS("/PM0" "gmoverid") ?y dB20((OS("/PM0" "gm") / OS("/PM0" "gds"))))
  Output fT,p*Aintr,p vs gm/ID,p = waveVsWave(?x OS("/PM0" "gmoverid") ?y ((OS("/PM0" "gm") / (2 * pi * OS("/PM0" "cgg"))) * (OS("/PM0" "gm") / OS("/PM0" "gds"))))
  Output |ID,p|/W vs gm/ID,p = waveVsWave(?x OS("/PM0" "gmoverid") ?y (abs(IS("/PM0/D")) / (VAR("NFp") * VAR("WFp"))))
  Output Vth,n = OS("/NM0" "vth") (unticked)
  Output IDn = IS("/NM0/D") (unticked)
  Output gm,n = OS("/NM0" "gm") (unticked)
  Output 1/gds,n = (1 / OS("/NM0" "gds")) (unticked)
  Output gm/ID,n = OS("/NM0" "gmoverid") (unticked)
  Output fT,n = (OS("/NM0" "gm") / (2 * pi * OS("/NM0" "cgg"))) (unticked)
  Output (Aintr,n)dB = dB20((OS("/NM0" "gm") / OS("/NM0" "gds"))) (unticked)
  Output fT,n*Aintr,n = ((OS("/NM0" "gm") / (2 * pi * OS("/NM0" "cgg"))) * (OS("/NM0" "gm") / OS("/NM0" "gds"))) (unticked)
  Output gm,n vs gm/ID,n = waveVsWave(?x OS("/NM0" "gmoverid") ?y OS("/NM0" "gm")) (unticked)
  Output 1/gds,n vs gm/ID,n = waveVsWave(?x OS("/NM0" "gmoverid") ?y (1 / OS("/NM0" "gds"))) (unticked)
  Output fT,n vs gm/ID,n = waveVsWave(?x OS("/NM0" "gmoverid") ?y (OS("/NM0" "gm") / (2 * pi * OS("/NM0" "cgg")))) (unticked)
  Output Aintr,n vs gm/ID,n = waveVsWave(?x OS("/NM0" "gmoverid") ?y dB20((OS("/NM0" "gm") / OS("/NM0" "gds")))) (unticked)
  Output fT,n*Aintr,n vs gm/ID,n = waveVsWave(?x OS("/NM0" "gmoverid") ?y ((OS("/NM0" "gm") / (2 * pi * OS("/NM0" "cgg"))) * (OS("/NM0" "gm") / OS("/NM0" "gds")))) (unticked)
  Output ID,n/W vs gm/ID,n = waveVsWave(?x OS("/NM0" "gmoverid") ?y (IS("/NM0/D") / (VAR("NFn") * VAR("WFn")))) (unticked)
Test gmoverid_plots_nch: PnD/gmoverid_plots/schematic, simulator spectre
  Models: /esat/micas-data/data/design/generic/045/gpdk045_v_4_0/gpdk045/../models/spectre/gpdk045.scs[mc]
  Variables: Ln = 360n; NFn = 10; WFn = 1.5u; VGSn = 500m; VDSn = 500m; VSBn = -500m; Lp = 360n; NFp = 10; WFp = 1u; VGSp = -500m; VDSp = -500m; VSBp = 0
  Temperature: 27
  Analysis dc: sweep VGSn start=0 stop=1 step=10m (saves the operating point)
  Output |Vth,p| = abs(OS("/PM0" "vth")) (unticked)
  Output |IDp| = abs(IS("/PM0/D")) (unticked)
  Output gm,p = OS("/PM0" "gm") (unticked)
  Output 1/gds,p = (1 / OS("/PM0" "gds")) (unticked)
  Output gm/ID,p = OS("/PM0" "gmoverid") (unticked)
  Output fT,p = (OS("/PM0" "gm") / (2 * pi * OS("/PM0" "cgg"))) (unticked)
  Output (Aintr,p)dB = dB20((OS("/PM0" "gm") / OS("/PM0" "gds"))) (unticked)
  Output fT,p*Aintr,p = ((OS("/PM0" "gm") / (2 * pi * OS("/PM0" "cgg"))) * (OS("/PM0" "gm") / OS("/PM0" "gds"))) (unticked)
  Output gm,p vs gm/ID,p = waveVsWave(?x OS("/PM0" "gmoverid") ?y OS("/PM0" "gm")) (unticked)
  Output 1/gds,p vs gm/ID,p = waveVsWave(?x OS("/PM0" "gmoverid") ?y (1 / OS("/PM0" "gds"))) (unticked)
  Output fT,p vs gm/ID,p = waveVsWave(?x OS("/PM0" "gmoverid") ?y (OS("/PM0" "gm") / (2 * pi * OS("/PM0" "cgg")))) (unticked)
  Output Aintr,p vs gm/ID,p = waveVsWave(?x OS("/PM0" "gmoverid") ?y dB20((OS("/PM0" "gm") / OS("/PM0" "gds")))) (unticked)
  Output fT,p*Aintr,p vs gm/ID,p = waveVsWave(?x OS("/PM0" "gmoverid") ?y ((OS("/PM0" "gm") / (2 * pi * OS("/PM0" "cgg"))) * (OS("/PM0" "gm") / OS("/PM0" "gds")))) (unticked)
  Output |ID,p|/W vs gm/ID,p = waveVsWave(?x OS("/PM0" "gmoverid") ?y (abs(IS("/PM0/D")) / (VAR("NFp") * VAR("WFp")))) (unticked)
  Output Vth,n = OS("/NM0" "vth")
  Output IDn = IS("/NM0/D")
  Output gm,n = OS("/NM0" "gm")
  Output 1/gds,n = (1 / OS("/NM0" "gds"))
  Output gm/ID,n = OS("/NM0" "gmoverid")
  Output fT,n = (OS("/NM0" "gm") / (2 * pi * OS("/NM0" "cgg")))
  Output (Aintr,n)dB = dB20((OS("/NM0" "gm") / OS("/NM0" "gds")))
  Output fT,n*Aintr,n = ((OS("/NM0" "gm") / (2 * pi * OS("/NM0" "cgg"))) * (OS("/NM0" "gm") / OS("/NM0" "gds")))
  Output gm,n vs gm/ID,n = waveVsWave(?x OS("/NM0" "gmoverid") ?y OS("/NM0" "gm"))
  Output 1/gds,n vs gm/ID,n = waveVsWave(?x OS("/NM0" "gmoverid") ?y (1 / OS("/NM0" "gds")))
  Output fT,n vs gm/ID,n = waveVsWave(?x OS("/NM0" "gmoverid") ?y (OS("/NM0" "gm") / (2 * pi * OS("/NM0" "cgg"))))
  Output Aintr,n vs gm/ID,n = waveVsWave(?x OS("/NM0" "gmoverid") ?y dB20((OS("/NM0" "gm") / OS("/NM0" "gds"))))
  Output fT,n*Aintr,n vs gm/ID,n = waveVsWave(?x OS("/NM0" "gmoverid") ?y ((OS("/NM0" "gm") / (2 * pi * OS("/NM0" "cgg"))) * (OS("/NM0" "gm") / OS("/NM0" "gds"))))
  Output ID,n/W vs gm/ID,n = waveVsWave(?x OS("/NM0" "gmoverid") ?y (IS("/NM0/D") / (VAR("NFn") * VAR("WFn"))))
Test gmoverid_plots_pch: PnD/gmoverid_plots/schematic, simulator spectre
  Models: /esat/micas-data/data/design/generic/045/gpdk045_v_4_0/gpdk045/../models/spectre/gpdk045.scs[mc]
  Variables: Ln = 360n; NFn = 10; WFn = 1.5u; VGSn = 500m; VDSn = 500m; VSBn = 0; Lp = 360n; NFp = 10; WFp = 1u; VGSp = -500m; VDSp = -500m; VSBp = 0
  Temperature: 27
  Analysis dc: sweep VGSp start=-1 stop=0 step=10m (saves the operating point)
  Output |Vth,p| = abs(OS("/PM0" "vth"))
  Output |IDp| = abs(IS("/PM0/D"))
  Output gm,p = OS("/PM0" "gm")
  Output 1/gds,p = (1 / OS("/PM0" "gds"))
  Output gm/ID,p = OS("/PM0" "gmoverid")
  Output fT,p = (OS("/PM0" "gm") / (2 * pi * OS("/PM0" "cgg")))
  Output (Aintr,p)dB = dB20((OS("/PM0" "gm") / OS("/PM0" "gds")))
  Output fT,p*Aintr,p = ((OS("/PM0" "gm") / (2 * pi * OS("/PM0" "cgg"))) * (OS("/PM0" "gm") / OS("/PM0" "gds")))
  Output gm,p vs gm/ID,p = waveVsWave(?x OS("/PM0" "gmoverid") ?y OS("/PM0" "gm"))
  Output 1/gds,p vs gm/ID,p = waveVsWave(?x OS("/PM0" "gmoverid") ?y (1 / OS("/PM0" "gds")))
  Output fT,p vs gm/ID,p = waveVsWave(?x OS("/PM0" "gmoverid") ?y (OS("/PM0" "gm") / (2 * pi * OS("/PM0" "cgg"))))
  Output Aintr,p vs gm/ID,p = waveVsWave(?x OS("/PM0" "gmoverid") ?y dB20((OS("/PM0" "gm") / OS("/PM0" "gds"))))
  Output fT,p*Aintr,p vs gm/ID,p = waveVsWave(?x OS("/PM0" "gmoverid") ?y ((OS("/PM0" "gm") / (2 * pi * OS("/PM0" "cgg"))) * (OS("/PM0" "gm") / OS("/PM0" "gds"))))
  Output |ID,p|/W vs gm/ID,p = waveVsWave(?x OS("/PM0" "gmoverid") ?y (abs(IS("/PM0/D")) / (VAR("NFp") * VAR("WFp"))))
  Output Vth,n = OS("/NM0" "vth") (unticked)
  Output IDn = IS("/NM0/D") (unticked)
  Output gm,n = OS("/NM0" "gm") (unticked)
  Output 1/gds,n = (1 / OS("/NM0" "gds")) (unticked)
  Output gm/ID,n = OS("/NM0" "gmoverid") (unticked)
  Output fT,n = (OS("/NM0" "gm") / (2 * pi * OS("/NM0" "cgg"))) (unticked)
  Output (Aintr,n)dB = dB20((OS("/NM0" "gm") / OS("/NM0" "gds"))) (unticked)
  Output fT,n*Aintr,n = ((OS("/NM0" "gm") / (2 * pi * OS("/NM0" "cgg"))) * (OS("/NM0" "gm") / OS("/NM0" "gds"))) (unticked)
  Output gm,n vs gm/ID,n = waveVsWave(?x OS("/NM0" "gmoverid") ?y OS("/NM0" "gm")) (unticked)
  Output 1/gds,n vs gm/ID,n = waveVsWave(?x OS("/NM0" "gmoverid") ?y (1 / OS("/NM0" "gds"))) (unticked)
  Output fT,n vs gm/ID,n = waveVsWave(?x OS("/NM0" "gmoverid") ?y (OS("/NM0" "gm") / (2 * pi * OS("/NM0" "cgg")))) (unticked)
  Output Aintr,n vs gm/ID,n = waveVsWave(?x OS("/NM0" "gmoverid") ?y dB20((OS("/NM0" "gm") / OS("/NM0" "gds")))) (unticked)
  Output fT,n*Aintr,n vs gm/ID,n = waveVsWave(?x OS("/NM0" "gmoverid") ?y ((OS("/NM0" "gm") / (2 * pi * OS("/NM0" "cgg"))) * (OS("/NM0" "gm") / OS("/NM0" "gds")))) (unticked)
  Output ID,n/W vs gm/ID,n = waveVsWave(?x OS("/NM0" "gmoverid") ?y (IS("/NM0/D") / (VAR("NFn") * VAR("WFn")))) (unticked)
Test gmoverid_plots_pch_lvt: PnD/gmoverid_plots_lvt/schematic, simulator spectre
  Models: /esat/micas-data/data/design/generic/045/gpdk045_v_4_0/gpdk045/../models/spectre/gpdk045.scs[mc]
  Variables: Lp = 360n; NFp = 1; WFp = 5u; VGSp = -500m; VDSp = -300m; VSBp = 0; Ln = 360n; NFn = 10; WFn = 1.5u; VGSn = 500m; VDSn = 500m; VSBn = 0
  Temperature: 27
  Analysis dc: sweep VGSp start=-1 stop=0 step=10m (saves the operating point)
  Output |Vth,p| = abs(OS("/PM0" "vth"))
  Output |IDp| = abs(IS("/PM0/D"))
  Output gm,p = OS("/PM0" "gm")
  Output 1/gds,p = (1 / OS("/PM0" "gds"))
  Output gm/ID,p = OS("/PM0" "gmoverid")
  Output fT,p = (OS("/PM0" "gm") / (2 * pi * OS("/PM0" "cgg")))
  Output (Aintr,p)dB = dB20((OS("/PM0" "gm") / OS("/PM0" "gds")))
  Output fT,p*Aintr,p = ((OS("/PM0" "gm") / (2 * pi * OS("/PM0" "cgg"))) * (OS("/PM0" "gm") / OS("/PM0" "gds")))
  Output gm,p vs gm/ID,p = waveVsWave(?x OS("/PM0" "gmoverid") ?y OS("/PM0" "gm"))
  Output 1/gds,p vs gm/ID,p = waveVsWave(?x OS("/PM0" "gmoverid") ?y (1 / OS("/PM0" "gds")))
  Output fT,p vs gm/ID,p = waveVsWave(?x OS("/PM0" "gmoverid") ?y (OS("/PM0" "gm") / (2 * pi * OS("/PM0" "cgg"))))
  Output Aintr,p vs gm/ID,p = waveVsWave(?x OS("/PM0" "gmoverid") ?y dB20((OS("/PM0" "gm") / OS("/PM0" "gds"))))
  Output fT,p*Aintr,p vs gm/ID,p = waveVsWave(?x OS("/PM0" "gmoverid") ?y ((OS("/PM0" "gm") / (2 * pi * OS("/PM0" "cgg"))) * (OS("/PM0" "gm") / OS("/PM0" "gds"))))
  Output |ID,p|/W vs gm/ID,p = waveVsWave(?x OS("/PM0" "gmoverid") ?y (abs(IS("/PM0/D")) / (VAR("NFp") * VAR("WFp"))))
  Output Vth,n = OS("/NM0" "vth") (unticked)
  Output IDn = IS("/NM0/D") (unticked)
  Output gm,n = OS("/NM0" "gm") (unticked)
  Output 1/gds,n = (1 / OS("/NM0" "gds")) (unticked)
  Output gm/ID,n = OS("/NM0" "gmoverid") (unticked)
  Output fT,n = (OS("/NM0" "gm") / (2 * pi * OS("/NM0" "cgg"))) (unticked)
  Output (Aintr,n)dB = dB20((OS("/NM0" "gm") / OS("/NM0" "gds"))) (unticked)
  Output fT,n*Aintr,n = ((OS("/NM0" "gm") / (2 * pi * OS("/NM0" "cgg"))) * (OS("/NM0" "gm") / OS("/NM0" "gds"))) (unticked)
  Output gm,n vs gm/ID,n = waveVsWave(?x OS("/NM0" "gmoverid") ?y OS("/NM0" "gm")) (unticked)
  Output 1/gds,n vs gm/ID,n = waveVsWave(?x OS("/NM0" "gmoverid") ?y (1 / OS("/NM0" "gds"))) (unticked)
  Output fT,n vs gm/ID,n = waveVsWave(?x OS("/NM0" "gmoverid") ?y (OS("/NM0" "gm") / (2 * pi * OS("/NM0" "cgg")))) (unticked)
  Output Aintr,n vs gm/ID,n = waveVsWave(?x OS("/NM0" "gmoverid") ?y dB20((OS("/NM0" "gm") / OS("/NM0" "gds")))) (unticked)
  Output fT,n*Aintr,n vs gm/ID,n = waveVsWave(?x OS("/NM0" "gmoverid") ?y ((OS("/NM0" "gm") / (2 * pi * OS("/NM0" "cgg"))) * (OS("/NM0" "gm") / OS("/NM0" "gds")))) (unticked)
  Output ID,n/W vs gm/ID,n = waveVsWave(?x OS("/NM0" "gmoverid") ?y (IS("/NM0/D") / (VAR("NFn") * VAR("WFn")))) (unticked)
Test gmoverid_plots_nch_lvt: PnD/gmoverid_plots_lvt/schematic, simulator spectre
  Models: /esat/micas-data/data/design/generic/045/gpdk045_v_4_0/gpdk045/../models/spectre/gpdk045.scs[mc]
  Variables: Ln = 60n; NFn = 1; WFn = 0.2u; VGSn = 600m; VDSn = 600m; VSBn = 0; Lp = 360n; NFp = 10; WFp = 1u; VGSp = -500m; VDSp = -500m; VSBp = 0
  Temperature: 27
  Analysis dc: sweep VGSn start=0 stop=1 step=10m (saves the operating point)
  Output |Vth,p| = abs(OS("/PM0" "vth")) (unticked)
  Output |IDp| = abs(IS("/PM0/D")) (unticked)
  Output gm,p = OS("/PM0" "gm") (unticked)
  Output 1/gds,p = (1 / OS("/PM0" "gds")) (unticked)
  Output gm/ID,p = OS("/PM0" "gmoverid") (unticked)
  Output fT,p = (OS("/PM0" "gm") / (2 * pi * OS("/PM0" "cgg"))) (unticked)
  Output (Aintr,p)dB = dB20((OS("/PM0" "gm") / OS("/PM0" "gds"))) (unticked)
  Output fT,p*Aintr,p = ((OS("/PM0" "gm") / (2 * pi * OS("/PM0" "cgg"))) * (OS("/PM0" "gm") / OS("/PM0" "gds"))) (unticked)
  Output gm,p vs gm/ID,p = waveVsWave(?x OS("/PM0" "gmoverid") ?y OS("/PM0" "gm")) (unticked)
  Output 1/gds,p vs gm/ID,p = waveVsWave(?x OS("/PM0" "gmoverid") ?y (1 / OS("/PM0" "gds"))) (unticked)
  Output fT,p vs gm/ID,p = waveVsWave(?x OS("/PM0" "gmoverid") ?y (OS("/PM0" "gm") / (2 * pi * OS("/PM0" "cgg")))) (unticked)
  Output Aintr,p vs gm/ID,p = waveVsWave(?x OS("/PM0" "gmoverid") ?y dB20((OS("/PM0" "gm") / OS("/PM0" "gds")))) (unticked)
  Output fT,p*Aintr,p vs gm/ID,p = waveVsWave(?x OS("/PM0" "gmoverid") ?y ((OS("/PM0" "gm") / (2 * pi * OS("/PM0" "cgg"))) * (OS("/PM0" "gm") / OS("/PM0" "gds")))) (unticked)
  Output |ID,p|/W vs gm/ID,p = waveVsWave(?x OS("/PM0" "gmoverid") ?y (abs(IS("/PM0/D")) / (VAR("NFp") * VAR("WFp")))) (unticked)
  Output Vth,n = OS("/NM0" "vth")
  Output IDn = IS("/NM0/D")
  Output gm,n = OS("/NM0" "gm")
  Output 1/gds,n = (1 / OS("/NM0" "gds"))
  Output gm/ID,n = OS("/NM0" "gmoverid")
  Output fT,n = (OS("/NM0" "gm") / (2 * pi * OS("/NM0" "cgg")))
  Output (Aintr,n)dB = dB20((OS("/NM0" "gm") / OS("/NM0" "gds")))
  Output fT,n*Aintr,n = ((OS("/NM0" "gm") / (2 * pi * OS("/NM0" "cgg"))) * (OS("/NM0" "gm") / OS("/NM0" "gds")))
  Output gm,n vs gm/ID,n = waveVsWave(?x OS("/NM0" "gmoverid") ?y OS("/NM0" "gm"))
  Output 1/gds,n vs gm/ID,n = waveVsWave(?x OS("/NM0" "gmoverid") ?y (1 / OS("/NM0" "gds")))
  Output fT,n vs gm/ID,n = waveVsWave(?x OS("/NM0" "gmoverid") ?y (OS("/NM0" "gm") / (2 * pi * OS("/NM0" "cgg"))))
  Output Aintr,n vs gm/ID,n = waveVsWave(?x OS("/NM0" "gmoverid") ?y dB20((OS("/NM0" "gm") / OS("/NM0" "gds"))))
  Output fT,n*Aintr,n vs gm/ID,n = waveVsWave(?x OS("/NM0" "gmoverid") ?y ((OS("/NM0" "gm") / (2 * pi * OS("/NM0" "cgg"))) * (OS("/NM0" "gm") / OS("/NM0" "gds"))))
  Output ID,n/W vs gm/ID,n = waveVsWave(?x OS("/NM0" "gmoverid") ?y (IS("/NM0/D") / (VAR("NFn") * VAR("WFn"))))
Test gmoverid_plots_pch_hvt: PnD/gmoverid_plots_hvt/schematic, simulator spectre
  Models: /esat/micas-data/data/design/generic/045/gpdk045_v_4_0/gpdk045/../models/spectre/gpdk045.scs[mc]
  Variables: Lp = 360n; NFp = 1; WFp = 5u; VGSp = -500m; VDSp = -300m; VSBp = 0; Ln = 360n; NFn = 10; WFn = 1.5u; VGSn = 500m; VDSn = 500m; VSBn = 0
  Temperature: 27
  Analysis dc: sweep VGSp start=-1 stop=0 step=10m (saves the operating point)
  Output |Vth,p| = abs(OS("/PM0" "vth"))
  Output |IDp| = abs(IS("/PM0/D"))
  Output gm,p = OS("/PM0" "gm")
  Output 1/gds,p = (1 / OS("/PM0" "gds"))
  Output gm/ID,p = OS("/PM0" "gmoverid")
  Output fT,p = (OS("/PM0" "gm") / (2 * pi * OS("/PM0" "cgg")))
  Output (Aintr,p)dB = dB20((OS("/PM0" "gm") / OS("/PM0" "gds")))
  Output fT,p*Aintr,p = ((OS("/PM0" "gm") / (2 * pi * OS("/PM0" "cgg"))) * (OS("/PM0" "gm") / OS("/PM0" "gds")))
  Output gm,p vs gm/ID,p = waveVsWave(?x OS("/PM0" "gmoverid") ?y OS("/PM0" "gm"))
  Output 1/gds,p vs gm/ID,p = waveVsWave(?x OS("/PM0" "gmoverid") ?y (1 / OS("/PM0" "gds")))
  Output fT,p vs gm/ID,p = waveVsWave(?x OS("/PM0" "gmoverid") ?y (OS("/PM0" "gm") / (2 * pi * OS("/PM0" "cgg"))))
  Output Aintr,p vs gm/ID,p = waveVsWave(?x OS("/PM0" "gmoverid") ?y dB20((OS("/PM0" "gm") / OS("/PM0" "gds"))))
  Output fT,p*Aintr,p vs gm/ID,p = waveVsWave(?x OS("/PM0" "gmoverid") ?y ((OS("/PM0" "gm") / (2 * pi * OS("/PM0" "cgg"))) * (OS("/PM0" "gm") / OS("/PM0" "gds"))))
  Output |ID,p|/W vs gm/ID,p = waveVsWave(?x OS("/PM0" "gmoverid") ?y (abs(IS("/PM0/D")) / (VAR("NFp") * VAR("WFp"))))
  Output Vth,n = OS("/NM0" "vth") (unticked)
  Output IDn = IS("/NM0/D") (unticked)
  Output gm,n = OS("/NM0" "gm") (unticked)
  Output 1/gds,n = (1 / OS("/NM0" "gds")) (unticked)
  Output gm/ID,n = OS("/NM0" "gmoverid") (unticked)
  Output fT,n = (OS("/NM0" "gm") / (2 * pi * OS("/NM0" "cgg"))) (unticked)
  Output (Aintr,n)dB = dB20((OS("/NM0" "gm") / OS("/NM0" "gds"))) (unticked)
  Output fT,n*Aintr,n = ((OS("/NM0" "gm") / (2 * pi * OS("/NM0" "cgg"))) * (OS("/NM0" "gm") / OS("/NM0" "gds"))) (unticked)
  Output gm,n vs gm/ID,n = waveVsWave(?x OS("/NM0" "gmoverid") ?y OS("/NM0" "gm")) (unticked)
  Output 1/gds,n vs gm/ID,n = waveVsWave(?x OS("/NM0" "gmoverid") ?y (1 / OS("/NM0" "gds"))) (unticked)
  Output fT,n vs gm/ID,n = waveVsWave(?x OS("/NM0" "gmoverid") ?y (OS("/NM0" "gm") / (2 * pi * OS("/NM0" "cgg")))) (unticked)
  Output Aintr,n vs gm/ID,n = waveVsWave(?x OS("/NM0" "gmoverid") ?y dB20((OS("/NM0" "gm") / OS("/NM0" "gds")))) (unticked)
  Output fT,n*Aintr,n vs gm/ID,n = waveVsWave(?x OS("/NM0" "gmoverid") ?y ((OS("/NM0" "gm") / (2 * pi * OS("/NM0" "cgg"))) * (OS("/NM0" "gm") / OS("/NM0" "gds")))) (unticked)
  Output ID,n/W vs gm/ID,n = waveVsWave(?x OS("/NM0" "gmoverid") ?y (IS("/NM0/D") / (VAR("NFn") * VAR("WFn")))) (unticked)
Test gmoverid_plots_nch_hvt: PnD/gmoverid_plots_hvt/schematic, simulator spectre
  Models: /esat/micas-data/data/design/generic/045/gpdk045_v_4_0/gpdk045/../models/spectre/gpdk045.scs[mc]
  Variables: Ln = 360n; NFn = 1; WFn = 200n; VGSn = 1300m; VDSn = 1300m; VSBn = 0; Lp = 360n; NFp = 10; WFp = 1u; VGSp = -500m; VDSp = -500m; VSBp = 0
  Temperature: 27
  Analysis dc: sweep VGSn start=0 stop=1 step=10m (saves the operating point)
  Output |Vth,p| = abs(OS("/PM0" "vth")) (unticked)
  Output |IDp| = abs(IS("/PM0/D")) (unticked)
  Output gm,p = OS("/PM0" "gm") (unticked)
  Output 1/gds,p = (1 / OS("/PM0" "gds")) (unticked)
  Output gm/ID,p = OS("/PM0" "gmoverid") (unticked)
  Output fT,p = (OS("/PM0" "gm") / (2 * pi * OS("/PM0" "cgg"))) (unticked)
  Output (Aintr,p)dB = dB20((OS("/PM0" "gm") / OS("/PM0" "gds"))) (unticked)
  Output fT,p*Aintr,p = ((OS("/PM0" "gm") / (2 * pi * OS("/PM0" "cgg"))) * (OS("/PM0" "gm") / OS("/PM0" "gds"))) (unticked)
  Output gm,p vs gm/ID,p = waveVsWave(?x OS("/PM0" "gmoverid") ?y OS("/PM0" "gm")) (unticked)
  Output 1/gds,p vs gm/ID,p = waveVsWave(?x OS("/PM0" "gmoverid") ?y (1 / OS("/PM0" "gds"))) (unticked)
  Output fT,p vs gm/ID,p = waveVsWave(?x OS("/PM0" "gmoverid") ?y (OS("/PM0" "gm") / (2 * pi * OS("/PM0" "cgg")))) (unticked)
  Output Aintr,p vs gm/ID,p = waveVsWave(?x OS("/PM0" "gmoverid") ?y dB20((OS("/PM0" "gm") / OS("/PM0" "gds")))) (unticked)
  Output fT,p*Aintr,p vs gm/ID,p = waveVsWave(?x OS("/PM0" "gmoverid") ?y ((OS("/PM0" "gm") / (2 * pi * OS("/PM0" "cgg"))) * (OS("/PM0" "gm") / OS("/PM0" "gds")))) (unticked)
  Output |ID,p|/W vs gm/ID,p = waveVsWave(?x OS("/PM0" "gmoverid") ?y (abs(IS("/PM0/D")) / (VAR("NFp") * VAR("WFp")))) (unticked)
  Output Vth,n = OS("/NM0" "vth")
  Output IDn = IS("/NM0/D")
  Output gm,n = OS("/NM0" "gm")
  Output 1/gds,n = (1 / OS("/NM0" "gds"))
  Output gm/ID,n = OS("/NM0" "gmoverid")
  Output fT,n = (OS("/NM0" "gm") / (2 * pi * OS("/NM0" "cgg")))
  Output (Aintr,n)dB = dB20((OS("/NM0" "gm") / OS("/NM0" "gds")))
  Output fT,n*Aintr,n = ((OS("/NM0" "gm") / (2 * pi * OS("/NM0" "cgg"))) * (OS("/NM0" "gm") / OS("/NM0" "gds")))
  Output gm,n vs gm/ID,n = waveVsWave(?x OS("/NM0" "gmoverid") ?y OS("/NM0" "gm"))
  Output 1/gds,n vs gm/ID,n = waveVsWave(?x OS("/NM0" "gmoverid") ?y (1 / OS("/NM0" "gds")))
  Output fT,n vs gm/ID,n = waveVsWave(?x OS("/NM0" "gmoverid") ?y (OS("/NM0" "gm") / (2 * pi * OS("/NM0" "cgg"))))
  Output Aintr,n vs gm/ID,n = waveVsWave(?x OS("/NM0" "gmoverid") ?y dB20((OS("/NM0" "gm") / OS("/NM0" "gds"))))
  Output fT,n*Aintr,n vs gm/ID,n = waveVsWave(?x OS("/NM0" "gmoverid") ?y ((OS("/NM0" "gm") / (2 * pi * OS("/NM0" "cgg"))) * (OS("/NM0" "gm") / OS("/NM0" "gds"))))
  Output ID,n/W vs gm/ID,n = waveVsWave(?x OS("/NM0" "gmoverid") ?y (IS("/NM0/D") / (VAR("NFn") * VAR("WFn"))))
