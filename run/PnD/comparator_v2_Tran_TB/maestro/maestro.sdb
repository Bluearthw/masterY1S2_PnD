ADE simulation setup
Run mode: Single Run, Sweeps and Corners
Tests:
  PnD_comparator_v2_Tran_TB_1: PnD/comparator_v2_Tran_TB/schematic, simulator spectre
    Variables: fsar = 1.6M; v1 = 697m; v2 = 703mm; v3 = 200m; v4 = 703m; VDD = 1.4; VSS = 0; vclk = 1.4; v_cmp2 = 700m
