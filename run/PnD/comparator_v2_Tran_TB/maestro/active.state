ADE simulation setup
Test PnD_comparator_v2_Tran_TB_1: PnD/comparator_v2_Tran_TB/schematic, simulator spectre
  Models: /esat/micas-data/data/design/tsmc65_students/PDK/tsmcN65//../models/spectre/toplevel.scs[tt_lib]
  Variables: v_cmp2 = 700m; fsar = 1.6M; v1 = 697m; v2 = 703mm; v3 = 200m; v4 = 703m; VDD = 1.4; VSS = 0; vclk = 1.4
  Temperature: 27
  Analysis dc: (saves the operating point)
  Analysis tran: stop=6/VAR("fsar")
  Signals: /out+, /clk, /out_dm
Run mode: Single Run, Sweeps and Corners
