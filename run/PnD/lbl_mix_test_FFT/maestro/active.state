ADE simulation setup
Test PnD_lbl_mix_test_1: PnD/lbl_mix_test_FFT/config, simulator ams
  Models: /esat/micas-data/data/design/tsmc65_students/PDK/tsmcN65//../models/spectre/toplevel.scs[mismatch_lib]
  Variables: fclk = 2048k; fin = 20.1k; sw1 = 0; sw2 = 0; sw3 = 0; sw4 = 0; sw5 = 0; sw6 = 0; vac = 1; vcm = 0.681; VDD = 1.4; vin = 1m; VSS = 0
  Temperature: 27
  Analysis tran: stop=10.1m errpreset=conservative
  Analysis dc: (saves the operating point)
  Output d2a_analogout = awvDigital2Analog(awvCreateBus("analogout" list(awvAnalog2Digital(VT("/readout<7>") nil nil 0.7 nil "centre") awvAnalog2Digital(VT("/readout<6>") nil nil 0.7 nil "centre") awvAnalog2Digital(VT("/readout<5>") nil nil 0.7 nil "centre") awvAnalog2Digital(VT("/readout<4>") nil nil 0.7 nil "centre") awvAnalog2Digital(VT("/readout<3>") nil nil 0.7 nil "centre") awvAnalog2Digital(VT("/readout<2>") nil nil 0.7 nil "centre") awvAnalog2Digital(VT("/readout<1>") nil nil 0.7 nil "centre") awvAnalog2Digital(VT("/readout<0>") nil nil 0.7 nil "centre")) "Binary") 1.4 0.0 "(vhi+vlo)/2" ?mode "busvalue" ?outWaveType "pwl" ?risetime 0.0 ?falltime 0.0)
  Output d2a_analog_zeroT = awvDigital2Analog(awvCreateBus("analog_zeroT" list(awvAnalog2Digital(VT("/readout<7>") nil nil 0.7 nil "centre") awvAnalog2Digital(VT("/readout<6>") nil nil 0.7 nil "centre") awvAnalog2Digital(VT("/readout<5>") nil nil 0.7 nil "centre") awvAnalog2Digital(VT("/readout<4>") nil nil 0.7 nil "centre") awvAnalog2Digital(VT("/readout<3>") nil nil 0.7 nil "centre") awvAnalog2Digital(VT("/readout<2>") nil nil 0.7 nil "centre") awvAnalog2Digital(VT("/readout<1>") nil nil 0.7 nil "centre") awvAnalog2Digital(VT("/readout<0>") nil nil 0.7 nil "centre")) "Binary") 1.4 0.0 "(vhi+vlo)/2" ?mode "busvalue" ?outWaveType "zeroT" ?risetime 0.0 ?falltime 0.0)
  Signals: /adc_out, /vraw, /vin, /clk, /cmp_clk, /readout<7:0>
Run mode: Single Run, Sweeps and Corners
