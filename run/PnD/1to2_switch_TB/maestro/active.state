ADE simulation setup
Test PnD_1to2_switch_TB_1: PnD/1to2_switch_TB/schematic, simulator spectre
  Models: /esat/micas-data/data/design/tsmc65_students/PDK/tsmcN65//../models/spectre/toplevel.scs[tt_lib]
  Variables: vref_minus = -0.7; vref_pos = 0.7; ctrl = 0.7
  Temperature: 27
  Analysis dc: (saves the operating point)
  Signals: /net13
Run mode: Single Run, Sweeps and Corners
