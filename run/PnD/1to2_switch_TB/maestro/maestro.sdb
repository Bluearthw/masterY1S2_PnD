ADE simulation setup
Run mode: Single Run, Sweeps and Corners
Tests:
  PnD_1to2_switch_TB_1: PnD/1to2_switch_TB/schematic, simulator spectre
    Variables: ctrl = 0.7; vref_minus = -0.7; vref_pos = 0.7
