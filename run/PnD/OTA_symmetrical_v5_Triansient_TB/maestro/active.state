ADE simulation setup
Test PnD_OTA_symmetrical_v5_Triansient_TB_1: PnD/OTA_symmetrical_v5_Triansient_TB/schematic, simulator spectre
  Models: /esat/micas-data/data/design/tsmc65_students/PDK/tsmcN65//../models/spectre/toplevel.scs[tt_lib]
  Variables: VINCM = 0.681; fin = 20k; VCM = 0.7; VDD = 1.4; vin = 2.5m
  Temperature: 27
  Analysis ac: start=1 stop=1G
  Analysis dc: (saves the operating point)
  Analysis tran: stop=5/VAR("fin")
  Output v /vout; ac deg(V) = phaseDegUnwrapped(vfreq('ac "/vout"))
  Output v /vout; ac dB20(V) = db(vfreq('ac "/vout"))
  Signals: /vin, /net2, /vout, /I0/vout_inter
Run mode: Single Run, Sweeps and Corners
