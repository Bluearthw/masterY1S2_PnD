ADE simulation setup
Run mode: Single Run, Sweeps and Corners
Tests:
  PnD_OTA_symmetrical_v5_Triansient_TB_1: PnD/OTA_symmetrical_v5_Triansient_TB/schematic, simulator spectre
    Variables: fin = 20k; VCM = 0.7; VDD = 1.4; vin = 2.5m; VINCM = 0.681
