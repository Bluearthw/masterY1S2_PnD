ADE simulation setup
Test PnD_dac_v1_transient_approx_TB_1: PnD/dac_v1_transient_approx_TB/schematic, simulator spectre
  Models: /esat/micas-data/data/design/tsmc65_students/PDK/tsmcN65//../models/spectre/toplevel.scs[tt_lib]
  Variables: fsample = 200k; fsw0 = 200k; fsw1 = 200k; fsw2 = 200k; fsw3 = 200k; fsw4 = 200k; fsw5 = 200k; fsw6 = 200k; fsw7 = 200k; VCM = 0; vin = 400m; fin = 20k
  Temperature: 27
  Analysis dc: (saves the operating point)
  Analysis tran: stop=1/VAR("fsample")
  Signals: /vout, /vin, /net11, /net6, /net10, /net12, /net14, /net19, /net15, /net16, /net1, /I1/net18
Run mode: Single Run, Sweeps and Corners
