ADE simulation setup
Run mode: Single Run, Sweeps and Corners
Tests:
  PnD_dac_v1_transient_approx_TB_1: PnD/dac_v1_transient_approx_TB/schematic, simulator spectre
    Variables: fin = 20k; fsample = 200k; fsw0 = 200k; fsw1 = 200k; fsw2 = 200k; fsw3 = 200k; fsw4 = 200k; fsw5 = 200k; fsw6 = 200k; fsw7 = 200k; VCM = 0; vin = 400m
