ADE simulation setup
Test PnD_1to3_switch_TB_1: PnD/1to3_switch_TB/config, simulator ams
  Models: /esat/micas-data/data/design/tsmc65_students/PDK/tsmcN65//../models/spectre/toplevel.scs[tt_lib]
  Variables: fin = 20k; fsw = 1.6M; vin = 0.5
  Temperature: 27
  Analysis dc: (saves the operating point)
  Analysis tran: stop=3/VAR("fin") errpreset=conservative
  Signals: /clk, /vref_ctrl, /vin_ctrl, /vin, /vout
Run mode: Single Run, Sweeps and Corners
