ADE simulation setup
Run mode: Single Run, Sweeps and Corners
Tests:
  PnD_1to3_switch_TB_1: PnD/1to3_switch_TB/config, simulator ams
    Variables: fin = 20k; fsw = 1.6M; vin = 0.5
