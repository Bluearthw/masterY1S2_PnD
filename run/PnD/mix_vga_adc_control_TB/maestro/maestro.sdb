ADE simulation setup
Run mode: Single Run, Sweeps and Corners
Tests:
  PnD_mix_vga_adc_control_TB_1: PnD/mix_vga_adc_control_TB/config, simulator ams
    Variables: fin = 20K; vac = 1; VDD = 1.4; vin = 0.05; vcm = 0.681
