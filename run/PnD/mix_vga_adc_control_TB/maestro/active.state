ADE simulation setup
Test PnD_mix_vga_adc_control_TB_1: PnD/mix_vga_adc_control_TB/config, simulator ams
  Models: /esat/micas-data/data/design/tsmc65_students/PDK/tsmcN65//../models/spectre/toplevel.scs[tt_lib]
  Variables: fin = 20K; vac = 1; VDD = 1.4; vin = 0.05; vcm = 0.681
  Temperature: 27
  Analysis tran: stop=6/VAR("fin") errpreset=conservative
  Signals: /readout1<7:0> as adc_unsigned, /signed_digital<7:0>, /vin, /vout_vga
Run mode: Single Run, Sweeps and Corners
