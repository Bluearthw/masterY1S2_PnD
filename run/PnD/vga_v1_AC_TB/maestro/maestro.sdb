ADE simulation setup
Run mode: Single Run, Sweeps and Corners
Tests:
  PnD_vga_v1_AC_TB_1: PnD/vga_v1_AC_TB/schematic, simulator spectre
    Variables: sw1 = 0,1.4; sw2 = 0,1.4; sw3 = 0,1.4; VDD = 0.7; VSS = -0.7
    Outputs: /vout
