ADE simulation setup
Test PnD_vga_v1_AC_TB_1: PnD/vga_v1_AC_TB/schematic, simulator spectre
  Models: /esat/micas-data/data/design/tsmc65_students/PDK/tsmcN65//../models/spectre/toplevel.scs[tt_lib]
  Variables: sw1 = 0,1.4; sw2 = 0,1.4; sw3 = 0,1.4; VDD = 0.7; VSS = -0.7
  Temperature: 27
  Analysis ac: start=1 stop=1G
  Signals: /vout
Run mode: Single Run, Sweeps and Corners
