ADE simulation setup
Run mode: Single Run, Sweeps and Corners
Tests:
  PnD_dac_v3_TB_1: PnD/dac_v3_TB/config, simulator ams
    Variables: fclk = 1.6M; fin = 20k; vcm = 0.7; VDD = 1.4; vin = 500m
    Outputs: /net1<0:7>
