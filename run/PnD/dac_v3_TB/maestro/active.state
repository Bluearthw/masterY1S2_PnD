ADE simulation setup
Test PnD_dac_v2_TB_1: PnD/dac_v2_TB/config, simulator ams
  Models: /esat/micas-data/data/design/tsmc65_students/PDK/tsmcN65//../models/spectre/toplevel.scs[tt_lib]
  Variables: fclk = 16M; fin = 20k; vcm = 0.7; VDD = 1.4; vin = 500m
  Temperature: 27
  Analysis dc: (saves the operating point)
  Analysis tran: stop=2/VAR("fin") errpreset=conservative
  Output awvCreateBus("READ" list(awvAnalog2Digital(VT("/readout<7>") nil nil 0.7 nil "centre") awvAnalog2Digital(VT("/readout<6>") nil nil 0.7 nil "centre") awvAnalog2Digital(VT("/readout<5>") nil nil 0.7 nil "centre") awvAnalog2Digital(VT("/readout<4>") nil nil 0.7 nil "centre") awvAnalog2Digital(VT("/readout<3>") nil nil 0.7 nil "centre") awvAnalog2Digital(VT("/readout<2>") nil nil 0.7 nil "centre") awvAnalog2Digital(VT("/readout<1>") nil nil 0.7 nil "centre") awvAnalog2Digital(VT("/readout<0>") nil nil 0.7 nil "centre")) "Unsigned Decimal") (unticked)
  Output awvCreateBus("IDEAL" list(awvAnalog2Digital(VT("/ideal<7>") nil nil 0.7 nil "centre") awvAnalog2Digital(VT("/ideal<6>") nil nil 0.7 nil "centre") awvAnalog2Digital(VT("/ideal<5>") nil nil 0.7 nil "centre") awvAnalog2Digital(VT("/ideal<4>") nil nil 0.7 nil "centre") awvAnalog2Digital(VT("/ideal<3>") nil nil 0.7 nil "centre") awvAnalog2Digital(VT("/ideal<2>") nil nil 0.7 nil "centre") awvAnalog2Digital(VT("/ideal<1>") nil nil 0.7 nil "centre") awvAnalog2Digital(VT("/ideal<0>") nil nil 0.7 nil "centre")) "Unsigned Decimal") (unticked)
  Signals: /cmp, /clk, /vin_ctrl, /vout, /net1<0:7>, /vin, /cmp_clk, /cmp_out_+, /cmp_out_-, /done, /readout<7:0>, /ideal<7:0>, /adc_out, /adc_ideal
Test PnD_dac_v3_TB_1: PnD/dac_v3_TB/config, simulator ams
  Models: /esat/micas-data/data/design/tsmc65_students/PDK/tsmcN65//../models/spectre/toplevel.scs[tt_lib]
  Variables: fclk = 1.6M; fin = 20k; vcm = 0.7; VDD = 1.4; vin = 500m
  Temperature: 27
  Analysis dc: (saves the operating point)
  Analysis tran: stop=3/VAR("fin") errpreset=conservative
  Output awvCreateBus("READ" list(awvAnalog2Digital(VT("/readout<7>") nil nil 0.7 nil "centre") awvAnalog2Digital(VT("/readout<6>") nil nil 0.7 nil "centre") awvAnalog2Digital(VT("/readout<5>") nil nil 0.7 nil "centre") awvAnalog2Digital(VT("/readout<4>") nil nil 0.7 nil "centre") awvAnalog2Digital(VT("/readout<3>") nil nil 0.7 nil "centre") awvAnalog2Digital(VT("/readout<2>") nil nil 0.7 nil "centre") awvAnalog2Digital(VT("/readout<1>") nil nil 0.7 nil "centre") awvAnalog2Digital(VT("/readout<0>") nil nil 0.7 nil "centre")) "Unsigned Decimal") (unticked)
  Output awvCreateBus("IDEAL" list(awvAnalog2Digital(VT("/ideal<7>") nil nil 0.7 nil "centre") awvAnalog2Digital(VT("/ideal<6>") nil nil 0.7 nil "centre") awvAnalog2Digital(VT("/ideal<5>") nil nil 0.7 nil "centre") awvAnalog2Digital(VT("/ideal<4>") nil nil 0.7 nil "centre") awvAnalog2Digital(VT("/ideal<3>") nil nil 0.7 nil "centre") awvAnalog2Digital(VT("/ideal<2>") nil nil 0.7 nil "centre") awvAnalog2Digital(VT("/ideal<1>") nil nil 0.7 nil "centre") awvAnalog2Digital(VT("/ideal<0>") nil nil 0.7 nil "centre")) "Unsigned Decimal") (unticked)
  Signals: /cmp, /clk, /vin_ctrl, /vout, /net1<0:7>, /vin, /cmp_clk, /cmp_out_+, /cmp_out_-, /done, /readout<7:0>, /ideal<7:0>, /adc_out, /adc_ideal
