ADE simulation setup
Run mode: Single Run, Sweeps and Corners
Tests:
  PnD_vga_v3_AC_TB_1: PnD/vga_v3_AC_TB/schematic, simulator spectre
    Variables: fin = 20k; sw1 = -0.6; sw2 = -0.6; sw3 = -0.6; sw4 = 0.6; sw5 = 0.6; sw6 = 0.6; vac = 1; VDD = 0.6; vin = 17.74m; VSS = -0.6
