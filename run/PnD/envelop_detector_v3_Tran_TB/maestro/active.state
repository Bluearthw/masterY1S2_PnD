ADE simulation setup
Test PnD_envelop_detector_v3_Tran_TB_1: PnD/envelop_detector_v3_Tran_TB/schematic, simulator spectre
  Models: /esat/micas-data/data/design/tsmc65_students/PDK/tsmcN65//../models/spectre/toplevel.scs[tt_lib]
  Variables: C_env1 = 1u; C_env2 = 1u; Cload = 1n; fin = 20k; VDD = 1.4; vin = 1m,10m,500m,1; VSS = -1.4
  Temperature: 27
  Analysis tran: stop=10/VAR("fin")
  Signals: /vout, /vrf
Run mode: Single Run, Sweeps and Corners
