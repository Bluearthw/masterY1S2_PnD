ADE simulation setup
Test PnD_vga_v2_AC_TB_1: PnD/vga_v2_AC_TB/schematic, simulator spectre
  Models: /esat/micas-data/data/design/tsmc65_students/PDK/tsmcN65//../models/spectre/toplevel.scs[tt_lib]
  Variables: vac = 0; vin = 100m; fin = 20k; sw1 = 0.7; sw2 = -0.7; sw3 = -0.7; sw4 = -0.7; sw5 = -0.7; sw6 = -0.7; VDD = 0.7; VSS = -0.7
  Temperature: 27
  Analysis dc: (saves the operating point)
  Analysis tran: stop=2/VAR("fin")
  Signals: /net1, /out
Run mode: Single Run, Sweeps and Corners
