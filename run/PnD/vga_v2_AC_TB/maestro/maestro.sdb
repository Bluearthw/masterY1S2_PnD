ADE simulation setup
Run mode: Single Run, Sweeps and Corners
Tests:
  PnD_vga_v2_AC_TB_1: PnD/vga_v2_AC_TB/schematic, simulator spectre
    Variables: sw1 = 0.7; sw2 = -0.7; sw3 = -0.7; sw4 = -0.7; sw5 = -0.7; sw6 = -0.7; VDD = 0.7; VSS = -0.7; fin = 20k; vin = 100m; vac = 0
