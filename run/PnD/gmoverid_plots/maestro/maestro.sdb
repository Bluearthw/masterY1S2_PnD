ADE simulation setup
Run mode: Single Run, Sweeps and Corners
Tests:
  gmoverid_plots_pch: PnD/gmoverid_plots/schematic, simulator spectre
    Variables: Lp = 360n; NFp = 14; WFp = 9.5u; VGSp = -500m; VDSp = -500m; VSBp = 0; Ln = 360n; NFn = 30; WFn = 1.5u; VGSn = 500m; VDSn = 500m; VSBn = 0
    Outputs: IDn; |IDp|; gm,n; gm,p; gm/ID,p; gm/ID,n; fT,n; fT,p; (Aintr,n)dB; (Aintr,p)dB; fT,n*Aintr,n; fT,p*Aintr,p; gm,n vs gm/ID,n; gm,p vs gm/ID,p; fT,n vs gm/ID,n; fT,p vs gm/ID,p; Aintr,n vs gm/ID,n; Aintr,p vs gm/ID,p; fT,n*Aintr,n vs gm/ID,n; fT,p*Aintr,p vs gm/ID,p; ID,n/W vs gm/ID,n; |ID,p|/W vs gm/ID,p; OS("/NM0" "gm"); Vth,n; |Vth,p|; 1/gds,n; 1/gds,p; 1/gds,n vs gm/ID,n; 1/gds,p vs gm/ID,p
  gmoverid_plots_nch: PnD/gmoverid_plots/schematic, simulator spectre
    Variables: VSBp = 0; Ln = 360n; NFn = 40; WFn = 2.202u; VGSn = 500m; VDSn = 500m; VSBn = 0,-500m; Lp = 360n; NFp = 10; WFp = 1u; VGSp = -500m; VDSp = -500m
    Outputs: IDn; |IDp|; gm,n; gm,p; gm/ID,p; gm/ID,n; fT,n; fT,p; (Aintr,n)dB; (Aintr,p)dB; fT,n*Aintr,n; fT,p*Aintr,p; gm,n vs gm/ID,n; gm,p vs gm/ID,p; fT,n vs gm/ID,n; fT,p vs gm/ID,p; Aintr,n vs gm/ID,n; Aintr,p vs gm/ID,p; fT,n*Aintr,n vs gm/ID,n; fT,p*Aintr,p vs gm/ID,p; ID,n/W vs gm/ID,n; |ID,p|/W vs gm/ID,p; OS("/NM0" "gm"); Vth,n; |Vth,p|; 1/gds,n; 1/gds,p; 1/gds,n vs gm/ID,n; 1/gds,p vs gm/ID,p
Global variables:
  Ln = 45n
Specs:
  gmoverid_plots_pch / gm,p: > 0.018
  gmoverid_plots_pch / fT,p*Aintr,p: > 690M
  gmoverid_plots_nch / gm,p: > 0.018
  gmoverid_plots_nch / fT,p*Aintr,p: > 690M
