ADE simulation setup
Run mode: Single Run, Sweeps and Corners
Tests:
  PnD_lbl_mix_test_1: PnD/lbl_mix_test_PNOISE/config, simulator ams
    Variables: fclk = 16M; fin = 20k; sw1 = 1.4; sw2 = 1.4; sw3 = 1.4; sw4 = 1.4; sw5 = 1.4; sw6 = 1.4; vac = 1; vcm = 0.682; VDD = 1.4; vin = 100m; VSS = 0
    Outputs: integ(VN2() 10 1000000.0)
