ADE simulation setup
Test PnD_lbl_mix_test_1: PnD/lbl_mix_test_PNOISE/config, simulator ams
  Models: /esat/micas-data/data/design/tsmc65_students/PDK/tsmcN65//../models/spectre/toplevel.scs[mismatch_lib]
  Variables: fclk = 16M; fin = 20k; sw1 = 1.4; sw2 = 1.4; sw3 = 1.4; sw4 = 1.4; sw5 = 1.4; sw6 = 1.4; vac = 1; vcm = 0.682; VDD = 1.4; vin = 100m; VSS = 0
  Temperature: 27
  Analysis stb: start=1 stop=1G probe=/I0/IPRB0 stbProbeMode=single-ended localgnd=/I0/VCM
  Analysis dc: (saves the operating point)
  Output VN2() = VN2() (unticked)
  Output integ(VN2() 10 1000000.0) (unticked)
  Output Loop Gain Phase = phaseDegUnwrapped(getData("loopGain" ?result "stb"))
  Output Loop Gain dB20 = db(mag(getData("loopGain" ?result "stb")))
  Signals: /adc_out, /vraw, /vin
Run mode: Single Run, Sweeps and Corners
