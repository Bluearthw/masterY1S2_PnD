ADE simulation setup
Run mode: Single Run, Sweeps and Corners
Tests:
  PnD_vga_v4_AC_TB_1: PnD/vga_v6_AC_TB/schematic, simulator spectre
    Variables: fin = 20k; sw1 = 0; sw2 = 0; sw3 = 0; sw4 = 1; sw5 = 1; sw6 = 1; vac = 1; VDD = 1.4; vin = 1m; VSS = 0
