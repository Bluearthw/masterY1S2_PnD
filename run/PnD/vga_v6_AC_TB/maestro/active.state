ADE simulation setup
Test PnD_vga_v3_AC_TB_1: PnD/vga_v3_AC_TB/schematic, simulator spectre
  Models: /esat/micas-data/data/design/tsmc65_students/PDK/tsmcN65//../models/spectre/toplevel.scs[tt_lib]
  Variables: fin = 20k; sw1 = -0.6; sw2 = -0.6; sw3 = -0.6; sw4 = 0.6; sw5 = 0.6; sw6 = 0.6; vac = 1; VDD = 0.6; vin = 17.74m; VSS = -0.6
  Temperature: 27
  Analysis ac: start=1 stop=1T dec=10
  Analysis dc: (saves the operating point)
  Analysis tran: stop=5/VAR("fin")
  Signals: /out, /net1
Test PnD_vga_v4_AC_TB_1: PnD/vga_v6_AC_TB/schematic, simulator spectre
  Models: /esat/micas-data/data/design/tsmc65_students/PDK/tsmcN65//../models/spectre/toplevel.scs[tt_lib]
  Variables: fin = 20k; sw1 = 0; sw2 = 0; sw3 = 0; sw4 = 1; sw5 = 1; sw6 = 1; vac = 1; VDD = 1.4; vin = 1m; VSS = 0
  Temperature: 27
  Analysis dc: (saves the operating point)
  Analysis ac: start=1 stop=1T dec=10
  Output v /out; ac dB20(V) = db(vfreq('ac "/out"))
  Output v /out; ac deg(V) = phaseDegUnwrapped(vfreq('ac "/out"))
