ADE simulation setup
Test PnD_dac_v1_transient_TB_1: PnD/dac_v1_transient_samplehold_TB/schematic, simulator spectre
  Models: /esat/micas-data/data/design/tsmc65_students/PDK/tsmcN65//../models/spectre/toplevel.scs[tt_lib]
  Variables: fsw = 200k; VCM = 0; fin = 20k; SW0 = 0.7; SW1 = 0.7; SW2 = 0.7; SW3 = 0.7; SW4 = 0.7; SW5 = 0.7; SW6 = 0.7; SW7 = 0.7; SW_SAMPLE = -0.7; vin = 0.5
  Temperature: 27
  Analysis dc: (saves the operating point)
  Analysis tran: stop=2/VAR("fin")
  Signals: /vout, /vin
Run mode: Single Run, Sweeps and Corners
