ADE simulation setup
Run mode: Single Run, Sweeps and Corners
Tests:
  PnD_dac_v1_transient_TB_1: PnD/dac_v1_transient_samplehold_TB/schematic, simulator spectre
    Variables: SW0 = 0.7; SW1 = 0.7; SW2 = 0.7; SW3 = 0.7; SW4 = 0.7; SW5 = 0.7; SW6 = 0.7; SW7 = 0.7; SW_SAMPLE = -0.7; vin = 0.5; fin = 20k; VCM = 0; fsw = 200k
