ADE simulation setup
Run mode: Single Run, Sweeps and Corners
Tests:
  PnD_OTA_rail2rail_v1_Transient_TB_1: PnD/OTA_rail2rail_v1_Transient_TB/schematic, simulator spectre
    Variables: Ibias_n = -0.3; Ibias_p = 0.3; vb1 = 0.5; vb2 = -0.5; VDD = 0.7; vrn = 0.5; vrp = -0.5; VSS = -0.7
    Outputs: /vout
