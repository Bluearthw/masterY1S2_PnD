ADE simulation setup
Test PnD_OTA_rail2rail_v1_Transient_TB_1: PnD/OTA_rail2rail_v1_Transient_TB/schematic, simulator spectre
  Models: /esat/micas-data/data/design/tsmc65_students/PDK/tsmcN65//../models/spectre/toplevel.scs[tt_lib]
  Variables: Ibias_n = -0.3; Ibias_p = 0.3; vb1 = 0.5; vb2 = -0.5; VDD = 0.7; vrn = 0.5; vrp = -0.5; VSS = -0.7
  Temperature: 27
  Analysis ac: start=1 stop=1G dec=10
  Analysis dc: (saves the operating point)
  Signals: /vout
Run mode: Single Run, Sweeps and Corners
