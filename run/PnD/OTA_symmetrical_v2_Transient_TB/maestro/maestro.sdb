ADE simulation setup
Run mode: Single Run, Sweeps and Corners
Tests:
  PnD_OTA_symmetrical_v2_Transient_TB_1: PnD/OTA_symmetrical_v2_Transient_TB/schematic, simulator spectre
    Variables: Ibias = 0.2; VDD = 0.7; VSS = -0.7; Wn_mirror = 120u; Wn_sym = 720u; Wp_Ibias = 120u; Wp_in = 360u; Wp_sym = 1u; L_sym = 600n; Ln_mirror = 60n; Lp_Ibias = 600n; Lp_in = 60n; Vbleed = -0.278; Ln_bleed = 600n; Wn_bleed = 120u; vin = 100m
