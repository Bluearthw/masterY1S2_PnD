ADE simulation setup
Test PnD_OTA_symmetrical_v2_Transient_TB_1: PnD/OTA_symmetrical_v2_Transient_TB/schematic, simulator spectre
  Models: /esat/micas-data/data/design/tsmc65_students/PDK/tsmcN65//../models/spectre/toplevel.scs[tt_lib]
  Variables: vin = 100m; Ln_bleed = 600n; Wn_bleed = 120u; Vbleed = -0.278; L_sym = 600n; Ln_mirror = 60n; Lp_Ibias = 600n; Lp_in = 60n; Wn_mirror = 120u; Wn_sym = 720u; Wp_Ibias = 120u; Wp_in = 360u; Wp_sym = 1u; Ibias = 0.2; VDD = 0.7; VSS = -0.7
  Temperature: 27
  Analysis dc: (saves the operating point)
  Analysis ac: start=1 stop=1G
  Analysis tran: stop=100u
  Signals: /vout
Run mode: Single Run, Sweeps and Corners
