ADE simulation setup
Test PnD_vga_v3_AC_TB_1: PnD/vga_v3_AC_TB/schematic, simulator spectre
  Models: /esat/micas-data/data/design/tsmc65_students/PDK/tsmcN65//../models/spectre/toplevel.scs[tt_lib]
  Variables: fin = 20k; sw1 = -0.6; sw2 = -0.6; sw3 = -0.6; sw4 = 0.6; sw5 = 0.6; sw6 = 0.6; vac = 1; VDD = 0.6; vin = 17.74m; VSS = -0.6
  Temperature: 27
  Analysis ac: start=1 stop=1T dec=10
  Analysis dc: (saves the operating point)
  Analysis tran: stop=5/VAR("fin")
  Signals: /out, /net1
Test PnD_vga_v4_AC_TB_1: PnD/vga_v5_AC_TB/schematic, simulator spectre
  Models: /esat/micas-data/data/design/tsmc65_students/PDK/tsmcN65//../models/spectre/toplevel.scs[tt_lib]
  Variables: fin = 20k; sw1 = 1.4; sw2 = 1.4; sw3 = 1.4; sw4 = 1.4; sw5 = 1.4; sw6 = 1.4; vac = 1; VDD = 1.4; vin = 56.1m; VSS = 0
  Temperature: 27
  Analysis tran: stop=5/VAR("fin")
  Analysis dc: (saves the operating point)
  Analysis ac: start=1 stop=1T dec=10
  Signals: /out, /net1
