ADE simulation setup
Run mode: Single Run, Sweeps and Corners
Tests:
  PnD_OTA_symmetrical_v4_Transient_TB_1: PnD/OTA_symmetrical_v4_Transient_TB/schematic, simulator spectre
    Variables: b1 = 0.45; b2 = 0.6; Ibias = 0.97265; VDD = 1.4; vin = 1m; VSS = 0; VCM = 0.681; bleed = 0.5; LP_IN = 90n; LP_LOAD = 90n; LP_CAS = 360n; LN_CAS = 360n; LN_MIR = 90n; LN_MIRCPY = 360n; WP_BIAS = 200n; WP_IN = 150u; WP_LOAD = 200n; WP_CAS = 2u; WN_CAS = 200n; WN_MIR = 200n; WN_MIRCPY = 1000n
