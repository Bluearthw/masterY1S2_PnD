ADE simulation setup
Test PnD_lbl_mix_test_1: PnD/lbl_mix_test/config, simulator ams
  Models: /esat/micas-data/data/design/tsmc65_students/PDK/tsmcN65//../models/spectre/toplevel.scs[mismatch_lib]
  Variables: fclk = 1600k; fin = 20k; sw1 = 1.4; sw2 = 1.4; sw3 = 1.4; sw4 = 1.4; sw5 = 1.4; sw6 = 1.4; vac = 1; vcm = 0.681; VDD = 1.4; vin = 100m; VSS = 0
  Temperature: 27
  Analysis dc: (saves the operating point)
  Analysis tran: stop=3/VAR("fin") errpreset=conservative
  Signals: /adc_out, /vraw, /vin, /clk, /cmp_clk
Run mode: Single Run, Sweeps and Corners
