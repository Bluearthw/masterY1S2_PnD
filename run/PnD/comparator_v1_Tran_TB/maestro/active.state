ADE simulation setup
Test PnD_comparator_v1_Tran_TB_1: PnD/comparator_v1_Tran_TB/schematic, simulator spectre
  Models: /esat/micas-data/data/design/tsmc65_students/PDK/tsmcN65//../models/spectre/toplevel.scs[tt_lib]
  Variables: vtest1 = 20m; vtest2 = -20m; fsar = 640k; vb = 0.8
  Temperature: 27
  Analysis dc: (saves the operating point)
  Analysis tran: stop=5/VAR("fsar")
  Signals: /vin+, /vin-, /vout
Run mode: Single Run, Sweeps and Corners
