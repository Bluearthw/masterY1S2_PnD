ADE simulation setup
Run mode: Single Run, Sweeps and Corners
Tests:
  PnD_comparator_v1_Tran_TB_1: PnD/comparator_v1_Tran_TB/schematic, simulator spectre
    Variables: vb = 0.8; fsar = 640k; vtest1 = 20m; vtest2 = -20m
