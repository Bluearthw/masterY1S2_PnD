ADE simulation setup
Run mode: Single Run, Sweeps and Corners
Tests:
  PnD_envelop_detector_v1_Tran_TB_1: PnD/envelop_detector_v1_Tran_TB/schematic, simulator spectre
    Variables: C_env1 = 10f; C_env2 = 10f; Cload = 1n; fin = 20k; vin = 100m, 1; VDD = 1.4; VSS = -1.4; w_pmos = 1059n
    Outputs: /vout; /vrf
