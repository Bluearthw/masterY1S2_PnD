ADE simulation setup
Test PnD_envelop_detector_v1_Tran_TB_1: PnD/envelop_detector_v1_Tran_TB/schematic, simulator spectre
  Models: /esat/micas-data/data/design/tsmc65_students/PDK/tsmcN65//../models/spectre/toplevel.scs[tt_lib]
  Variables: w_pmos = 1059n; VDD = 1.4; VSS = -1.4; C_env1 = 10f; C_env2 = 10f; Cload = 1n; fin = 20k; vin = 100m
  Temperature: 27
  Analysis tran: stop=20/VAR("fin") errpreset=conservative
  Signals: /vout, /vrf
Run mode: Single Run, Sweeps and Corners
Setup values for test PnD_envelop_detector_v1_Tran_TB_1: vin = 100m, 1
