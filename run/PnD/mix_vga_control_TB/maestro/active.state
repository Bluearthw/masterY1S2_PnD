ADE simulation setup
Test PnD_mix_vga_control_TB_1: PnD/mix_vga_control_TB/config, simulator ams
  Models: /esat/micas-data/data/design/tsmc65_students/PDK/tsmcN65//../models/spectre/toplevel.scs[tt_lib]
  Variables: fin = 10k; vac = 1; VDD = 1.4; vin = 5m; VSS = 0
  Temperature: 27
  Analysis tran: stop=2/VAR("fin") errpreset=conservative
  Signals: /net8, /net1, /net13, /control<5:0>, /vga_control_in<0>, /vga_control_in<1>, /vga_control_in<2>, /dm
Run mode: Single Run, Sweeps and Corners
