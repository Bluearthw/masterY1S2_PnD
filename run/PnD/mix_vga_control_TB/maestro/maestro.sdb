ADE simulation setup
Run mode: Single Run, Sweeps and Corners
Tests:
  PnD_mix_vga_control_TB_1: PnD/mix_vga_control_TB/config, simulator ams
