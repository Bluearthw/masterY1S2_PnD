ADE simulation setup
Run mode: Single Run, Sweeps and Corners
Tests:
  PnD_level_shifter_v1_TB_1: PnD/level_shifter_v1_TB/schematic, simulator spectre
    Variables: fin = 20k; R1 = 1k; R2 = 1k
    Outputs: /vin; /vout
