ADE simulation setup
Test PnD_level_shifter_v1_TB_1: PnD/level_shifter_v1_TB/schematic, simulator spectre
  Models: /esat/micas-data/data/design/tsmc65_students/PDK/tsmcN65//../models/spectre/toplevel.scs[tt_lib]
  Variables: R1 = 1k; R2 = 1k; fin = 20k
  Temperature: 27
  Analysis ac: start=1 stop=1G
  Analysis dc: (saves the operating point)
  Analysis tran: stop=5/VAR("fin")
  Signals: /vin, /vout
Run mode: Single Run, Sweeps and Corners
