ADE simulation setup
Run mode: Single Run, Sweeps and Corners
Tests:
  PnD_vga_v6_SR_TB_1: PnD/vga_v6_SR_TB/schematic, simulator spectre
    Variables: sw1 = 0; sw2 = 0; sw3 = 0; sw4 = 0; sw5 = 0; sw6 = 0; vac = 0.681; VDD = 1.4; VSS = 0; fin = 20k; vmax = 0.002+0.681; vmin = -0.002+0.681
