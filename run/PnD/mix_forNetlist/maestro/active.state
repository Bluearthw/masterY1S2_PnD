ADE simulation setup
Test PnD_mix_forNetlist_1: PnD/mix_forNetlist/schematic, simulator spectre
  Models: /esat/micas-data/data/design/tsmc65_students/PDK/tsmcN65//../models/spectre/toplevel.scs[tt_lib]
  Temperature: 27
  Analysis tran: stop=1m errpreset=liberal
  Signals: /net1
Run mode: Single Run, Sweeps and Corners
