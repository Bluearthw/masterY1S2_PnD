ADE simulation setup
Run mode: Single Run, Sweeps and Corners
Tests:
  PnD_mix_forNetlist_1: PnD/mix_forNetlist/schematic, simulator spectre
