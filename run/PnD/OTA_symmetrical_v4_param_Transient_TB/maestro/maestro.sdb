ADE simulation setup
Run mode: Single Run, Sweeps and Corners
Tests:
  PnD_OTA_symmetrical_v4_Transient_TB_1: PnD/OTA_symmetrical_v4_param_Transient_TB/schematic, simulator spectre
    Variables: b1 = 0.45; b2 = 0.6; Ibias = 0.97265; VDD = 1.4; vin = 1m; VSS = 0; VCM = 0.681; bleed = 0.5
