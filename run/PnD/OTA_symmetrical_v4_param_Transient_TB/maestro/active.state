ADE simulation setup
Test PnD_OTA_symmetrical_v3_Transient_TB_1: PnD/OTA_symmetrical_v3_Transient_TB/schematic, simulator spectre
  Models: /esat/micas-data/data/design/tsmc65_students/PDK/tsmcN65//../models/spectre/toplevel.scs[tt_lib]
  Variables: Ibias = 0.2; Vbleed = -0.278; VDD = 0.7; vin = 1; VSS = -0.7
  Temperature: 27
  Analysis dc: (saves the operating point)
  Analysis ac: start=1 stop=1T dec=10
  Analysis tran: stop=100u
  Output v /vout; ac dB20(V) = db(vfreq('ac "/vout"))
  Output v /vout; ac deg(V) = phaseDegUnwrapped(vfreq('ac "/vout"))
  Signals: /vout
Test PnD_OTA_symmetrical_v4_Transient_TB_1: PnD/OTA_symmetrical_v4_param_Transient_TB/schematic, simulator spectre
  Models: /esat/micas-data/data/design/tsmc65_students/PDK/tsmcN65//../models/spectre/toplevel.scs[tt_lib]
  Variables: b1 = 0.45; b2 = 0.6; Ibias = 0.97265; VDD = 1.4; vin = 1m; VSS = 0; VCM = 0.681; bleed = 0.5
  Temperature: 27
  Analysis ac: start=1 stop=1T dec=10
  Analysis dc: (saves the operating point)
  Analysis tran: stop=100u
  Output v /vout; ac dB20(V) = db(vfreq('ac "/vout"))
  Output v /vout; ac deg(V) = phaseDegUnwrapped(vfreq('ac "/vout"))
  Signals: /vout
