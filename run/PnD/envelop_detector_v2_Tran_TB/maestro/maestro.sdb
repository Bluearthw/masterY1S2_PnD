ADE simulation setup
Run mode: Single Run, Sweeps and Corners
Tests:
  PnD_envelop_detector_v2_Tran_TB_1: PnD/envelop_detector_v2_Tran_TB/schematic, simulator spectre
    Variables: C_env1 = 10m; Cload = 1n; fin = 20k; VDD = 1.4; vin = 1; VSS = -1.4; env_r1 = 25000k
