ADE simulation setup
Test PnD_envelop_detector_v2_Tran_TB_1: PnD/envelop_detector_v2_Tran_TB/schematic, simulator spectre
  Models: /esat/micas-data/data/design/tsmc65_students/PDK/tsmcN65//../models/spectre/toplevel.scs[tt_lib]
  Variables: env_r1 = 25000k; C_env1 = 10m; Cload = 1n; fin = 20k; VDD = 1.4; vin = 1; VSS = -1.4
  Temperature: 27
  Analysis tran: stop=10/VAR("fin")
  Signals: /vrf, /vout, /I4/buffer_in, /I4/buffer_out_1
Run mode: Single Run, Sweeps and Corners
