ADE simulation setup
Test gmsk_anatop_1: gmsk/cap_bank/schematic, simulator spectre
  Models: /esat/micas-data/data/design/tsmc65/PDK-2017/tsmcN65//../models/spectre/toplevel.scs[tt_lib]
  Temperature: 27
Run mode: Single Run, Sweeps and Corners
