ADE simulation setup
Run mode: Single Run, Sweeps and Corners
Tests:
  gmsk_anatop_1: gmsk/cap_bank/schematic, simulator spectre
