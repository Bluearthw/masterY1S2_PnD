ADE simulation setup
Test gmsk_anatop_1: gmsk/anatop/schematic, simulator spectre
  Models: /esat/micas-data/data/design/tsmc65/PDK-2017/tsmcN65//../models/spectre/toplevel.scs[tt_lib]
  Temperature: 27
  Analysis tran: stop=10n
Run mode: Single Run, Sweeps and Corners
