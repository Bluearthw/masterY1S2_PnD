ADE simulation setup
Run mode: Single Run, Sweeps and Corners
Tests:
  gmsk_anatop_tb_1: gmsk/anatop_tb/schematic, simulator spectre
    Variables: filter_C = 1n; filter_R = 10k; sampling_period = 10u; carrier_freq = 15k
