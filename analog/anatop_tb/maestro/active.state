ADE simulation setup
Test gmsk_anatop_tb_1: gmsk/anatop_tb/schematic, simulator spectre
  Models: /users/micas/micas/design/tsmc65_students/PDK/tsmcN65//../models/spectre/toplevel.scs[tt_lib]
  Variables: carrier_freq = 15k; filter_C = 1n; filter_R = 10k; sampling_period = 10u
  Temperature: 27
  Analysis tran: stop=1m
  Signals: /OUT, /IN, /en, /clk
Run mode: Single Run, Sweeps and Corners
